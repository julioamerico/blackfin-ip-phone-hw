|   Analog Devices INC.
|   IBIS Model of BF512/BF514/BF516/BF518
|   Embedded processor
|   176 Pin 24x24 LFQP
[IBIS ver]   3.2
[File name]   1_8_qfpa.ibs
[File Rev]   1.1
[Date]   09/15/2009
[Source]   From running Hspice on 90nm spice models.
[Notes]
|   Model data reflects 1.8v I/O Operation
|   No models exist for the following pins (Using type NC as
|   a placeholder):
|   XTAL, CLKIN, RTXI, RTXO
[Disclaimer]
|   This IBIS model is provided "AS IS, WHERE IS", AND WITH NO WARRANTY OF
|   ANY KIND EITHER EXPRESSED OR IMPLIED, INCLUDING BUT NOT LIMITED TO ANY
|   IMPLIED WARRANTIES OF MERCHANTABILITY AND FITNESS FOR A PARTICULAR
|   PURPOSE.  IN NO EVENT WILL ADI BE LIABLE FOR SPECIAL, COLLATERAL,
|   INCIDENTAL, OR CONSEQUENTIAL DAMAGES IN CONNECTION WITH OR ARISING OUT
|   OF THE USE OF THIS IBIS MODEL, AND IN NO EVENT SHALL ADI'S TOTAL
|   LIABILITY EXCEED $1,000, REGARDLESS OF THE BASIS FOR CLAIM.  ADI
|   RESERVES THE right to make changes to the products and IBIS models
|   without prior notice.
[Copyright]   This model is exclusive property of Analog Devices Inc
|   and is not to be resold or redistributed without the written
|   permission of Analog Devices.
|   Copyright (C)2008 Analog Devices, All Rights Reserved
[Component]   BF512/BF514/BF516/BF518
[Manufacturer] ANALOG DEVICES
[Package]
| variable   typ   min   max
R_pkg   0.221   0.144   0.255
L_pkg   14.194nH   11.92nH   16.39nH
C_pkg   3.205pF   1.87pF   3.75pF
[Pin]   signal_name   model_name   R_pin   L_pin   C_pin
  1   GND   GND   NA   NA   NA
  2   GND   GND   NA   NA   NA
  3   PF9   prw0408swcdg_25   NA   NA   NA
  4   PF8   prw0408swcdg_25   NA   NA   NA
  5   PF7   prw0408swcdg_25   NA   NA   NA
  6   PF6   prw0408swcdg_25   NA   NA   NA
  7   VDDEXT   POWER   NA   NA   NA
  8   VPPOTP   POWER   NA   NA   NA
  9   VDDOTP   POWER   NA   NA   NA
 10   PF5   prw0408swcdg_25   NA   NA   NA
 11   PF4   prw0408swcdg_25   NA   NA   NA
 12   PF3   prw0408swcdg_25   NA   NA   NA
 13   PF2   prw0408swcdg_25   NA   NA   NA
 14   VDDINT   POWER   NA   NA   NA
 15   GND   GND   NA   NA   NA
 16   VDDFLASH   POWER   NA   NA   NA
 17   VDDFLASH   POWER   NA   NA   NA
 18   PF1   prw0408swcdg_25   NA   NA   NA
 19   PF0   prw0408swcdg_25   NA   NA   NA
 20   PG15   prw0408swcdg_25   NA   NA   NA
 21   PG14   prw0408swcdg_25   NA   NA   NA
 22   GND   GND   NA   NA   NA
 23   VDDINT   POWER   NA   NA   NA
 24   VDDEXT   POWER   NA   NA   NA
 25   PG13   prw0408swcdg_25   NA   NA   NA
 26   PG12   prw0812swcdg_25   NA   NA   NA
 27   PG11   prw0408swcdg_25   NA   NA   NA
 28   PG10   prw0408swcdg_25   NA   NA   NA
 29   VDDFLASH   POWER   NA   NA   NA
 30   VDDINT   POWER   NA   NA   NA
 31   PG9   prw0408swcdg_25   NA   NA   NA
 32   PG8   prw0812swcdg_25   NA   NA   NA
 33   PG7   prw0408swcdg_25   NA   NA   NA
 34   PG6   pupd_0408_25pad   NA   NA   NA
 35   VDDEXT   POWER   NA   NA   NA
 36   PG5   pupd_0408_25pad   NA   NA   NA
 37   PG4   pupd_0812_25pad   NA   NA   NA
 38   PG3   pupd_0408_25pad   NA   NA   NA
 39   PG2   prw0408swcdg_25   NA   NA   NA
 40   BMODE2   prw0408swcdg_25   NA   NA   NA
 41   BMODE1   prw0408swcdg_25   NA   NA   NA
 42   BMODE0   prw0408swcdg_25   NA   NA   NA
 43   GND   GND   NA   NA   NA
 44   GND   GND   NA   NA   NA
 45   GND   GND   NA   NA   NA
 46   GND   GND   NA   NA   NA
 47   PG1   prw0408swcdg_25   NA   NA   NA
 48   PG0   prw0408swcdg_25   NA   NA   NA
 49   VDDEXT   POWER   NA   NA   NA
 50   TDO   prw0408swcdg_25   NA   NA   NA
 51   EMU   prw0408swcdg_25   NA   NA   NA
 52   TDI   prwd0408swcdg_25   NA   NA   NA
 53   TCK   prwd0408swcdg_25   NA   NA   NA
 54   TRST   prwd0408swcdg_25   NA   NA   NA
 55   TMS   prwd0408swcdg_25   NA   NA   NA
 56   D15   prw1216hcdg_25   NA   NA   NA
 57   D14   prw1216hcdg_25   NA   NA   NA
 58   D13   prw1216hcdg_25   NA   NA   NA
 59   VDDMEM   POWER   NA   NA   NA
 60   D12   prw1216hcdg_25   NA   NA   NA
 61   D11   prw1216hcdg_25   NA   NA   NA
 62   D10   prw1216hcdg_25   NA   NA   NA
 63   VDDINT   POWER   NA   NA   NA
 64   D9   prw1216hcdg_25   NA   NA   NA
 65   D8   prw1216hcdg_25   NA   NA   NA
 66   D7   prw1216hcdg_25   NA   NA   NA
 67   GND   GND   NA   NA   NA
 68   VDDMEM   POWER   NA   NA   NA
 69   D6   prw1216hcdg_25   NA   NA   NA
 70   D5   prw1216hcdg_25   NA   NA   NA
 71   D4   prw1216hcdg_25   NA   NA   NA
 72   D3   prw1216hcdg_25   NA   NA   NA
 73   D2   prw1216hcdg_25   NA   NA   NA
 74   D1   prw1216hcdg_25   NA   NA   NA
 75   VDDMEM   POWER   NA   NA   NA
 76   D0   prw1216hcdg_25   NA   NA   NA
 77   A19   prw1216cdg_25   NA   NA   NA
 78   A18   prw1216cdg_25   NA   NA   NA
 79   VDDINT   POWER   NA   NA   NA
 80   A17   prw1216cdg_25   NA   NA   NA
 81   A16   prw1216cdg_25   NA   NA   NA
 82   VDDMEM   POWER   NA   NA   NA
 83   GND   GND   NA   NA   NA
 84   A15   prw1216cdg_25   NA   NA   NA
 85   A14   prw1216cdg_25   NA   NA   NA
 86   A13   prw1216cdg_25   NA   NA   NA
 87   GND   GND   NA   NA   NA
 88   GND   GND   NA   NA   NA
 89   GND   GND   NA   NA   NA
 90   GND   GND   NA   NA   NA
 91   A12   prw1216cdg_25   NA   NA   NA
 92   A11   prw1216cdg_25   NA   NA   NA
 93   A10   prw1216cdg_25   NA   NA   NA
 94   A9   prw1216cdg_25   NA   NA   NA
 95   VDDMEM   POWER   NA   NA   NA
 96   A8   prw1216cdg_25   NA   NA   NA
 97   A7   prw1216cdg_25   NA   NA   NA
 98   VDDINT   POWER   NA   NA   NA
 99   GND   GND   NA   NA   NA
100   VDDINT   POWER   NA   NA   NA
101   A6   prw1216cdg_25   NA   NA   NA
102   A5   prw1216cdg_25   NA   NA   NA
103   A4   prw1216cdg_25   NA   NA   NA
104   VDDMEM   POWER   NA   NA   NA
105   A3   prw1216cdg_25   NA   NA   NA
106   A2   prw1216cdg_25   NA   NA   NA
107   A1   prw1216cdg_25   NA   NA   NA
108   ABE1   prw1216cdg_25   NA   NA   NA
109   ABE0   prw1216cdg_25   NA   NA   NA
110   SA10   prw1216cdg_25   NA   NA   NA
111   GND   GND   NA   NA   NA
112   VDDMEM   POWER   NA   NA   NA
113   SWE   prw1216cdg_25   NA   NA   NA
114   SCAS   prw1216cdg_25   NA   NA   NA
115   SRAS   prw1216cdg_25   NA   NA   NA
116   VDDINT   POWER   NA   NA   NA
117   GND   GND   NA   NA   NA
118   SMS   prw1216cdg_25   NA   NA   NA
119   SCKE   prw1216cdg_25   NA   NA   NA
120   AMS1   prw1216cdg_25   NA   NA   NA
121   ARE   prw1216cdg_25   NA   NA   NA
122   AWE   prw1216cdg_25   NA   NA   NA
123   AMS0   prw1216cdg_25   NA   NA   NA
124   VDDMEM   POWER   NA   NA   NA
125   CLKOUT   prw1624cdg_25   NA   NA   NA
126   VDDFLASH   POWER   NA   NA   NA
127   NC1   NC   NA   NA   NA
128   VDDEXT   POWER   NA   NA   NA
129   VDDEXT   POWER   NA   NA   NA
130   EXT_WAKE   prw0408swcdg_3v_25   NA   NA   NA
131   GND   GND   NA   NA   NA
132   GND   GND   NA   NA   NA
133   GND   GND   NA   NA   NA
134   GND   GND   NA   NA   NA
135   PG   prw0408swcdg_25   NA   NA   NA
136   VDDEXT   POWER   NA   NA   NA
137   GND   GND   NA   NA   NA
138   VDDINT   POWER   NA   NA   NA
139   GND   GND   NA   NA   NA
140   RTXO   NC   NA   NA   NA
141   RTXI   NC   NA   NA   NA
142   VDDRTC   POWER   NA   NA   NA
143   CLKIN   NC   NA   NA   NA
144   XTAL   NC   NA   NA   NA
145   VDDEXT   POWER   NA   NA   NA
146   RESET   prw0408swcdg_3v_25   NA   NA   NA
147   NMI   prw0408swcdg_25   NA   NA   NA
148   VDDEXT   POWER   NA   NA   NA
149   GND   GND   NA   NA   NA
150   CLKBUF   prw0408swcdg_3v_25   NA   NA   NA
151   GND   GND   NA   NA   NA
152   VDDINT   POWER   NA   NA   NA
153   PH7   prw0408swcdg_25   NA   NA   NA
154   PH6   prw0408swcdg_25   NA   NA   NA
155   PH5   prw0812swcdg_25   NA   NA   NA
156   PH4   prw0408swcdg_25   NA   NA   NA
157   GND   GND   NA   NA   NA
158   VDDEXT   POWER   NA   NA   NA
159   PH3   pupd_0408_25pad   NA   NA   NA
160   PH2   pupd_0812_25pad   NA   NA   NA
161   PH1   pupd_0408_25pad   NA   NA   NA
162   PH0   pupd_0408_25pad   NA   NA   NA
163   GND   GND   NA   NA   NA
164   VDDINT   POWER   NA   NA   NA
165   PF15   prw0408swcdg_3v_25   NA   NA   NA
166   PF14   prw0408swcdg_25   NA   NA   NA
167   PF13   prw0408swcdg_25   NA   NA   NA
168   PF12   prw0408swcdg_25   NA   NA   NA
169   GND   GND   NA   NA   NA
170   VDDEXT   POWER   NA   NA   NA
171   PF11   prw0408swcdg_25   NA   NA   NA
172   SDA   piic400kv123   NA   NA   NA
173   SCL   piic400kv123   NA   NA   NA
174   PF10   prw0408swcdg_25   NA   NA   NA
175   GND   GND   NA   NA   NA
176   GND   GND   NA   NA   NA
[Model Selector]   prw0408swcdg_25
COUT_8 8mA buffer
[Model Selector]   prwd0408swcdg_25
EOUT_8 8mA buffer
[Model Selector]   prw0408swcdg_3v_25
FOUT_8 8mA buffer
[Model Selector]   prw0812swcdg_25
IOUT_12 12mA buffer
[Model Selector]   prw1216cdg_25
MOUT_16 16mA buffer
[Model Selector]   prw1216hcdg_25
NOUT_16 16mA buffer
[Model Selector]   prw1624cdg_25
QOUT_24 24mA buffer
[Model Selector]   pupd_0408_25pad
ROUT_8NE 8mA buffer  None enabled
ROUT_8PU 8mA buffer  Pullup enabled
ROUT_8PD 8mA buffer  Pulldown enabled
[Model Selector]   pupd_0812_25pad
SOUT_12NE 12mA buffer  None enabled
SOUT_12PU 12mA buffer  Pullup enabled
[Model Selector]   piic400kv123
twi_s5 Vbus 1.8V
twi_s6 Vbus 2.5V
twi_s7 Vbus 3.3V
| Models and submodels in the file (15): twi_s5 (I/O_open_drain), twi_s6 (I/O_open_drain), twi_s7 (I/O_open_drain), COUT_8 (I/O), FOUT_8 (I/O), IOUT_12 (I/O), MOUT_16 (I/O), NOUT_16 (I/O), EOUT_8 (I/O), QOUT_24 (I/O), SOUT_12NE (I/O), SOUT_12PU (I/O), ROUT_8NE (I/O), ROUT_8PD (I/O), ROUT_8PU (I/O)
